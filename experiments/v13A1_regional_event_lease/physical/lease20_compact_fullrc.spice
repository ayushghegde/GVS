* NGSPICE file created from lease20_compact_flat.ext - technology: sky130A

.subckt lease20_compact_flat PRE OK DONE EVT OUT LEAKG GND
X0 OUT.t0 WAKE.t5 EVT.t0 GND sky130_fd_pr__nfet_01v8 ad=0.1596 pd=1.6 as=0.1554 ps=1.58 w=0.42 l=0.15
X1 PRE.t1 PRE.t0 WAKE.t1 GND sky130_fd_pr__nfet_01v8 ad=0.1596 pd=1.6 as=0.1554 ps=1.58 w=0.42 l=0.15
X2 OK.t1 OK.t0 WAKE.t2 GND sky130_fd_pr__nfet_01v8 ad=0.1596 pd=1.6 as=0.1554 ps=1.58 w=0.42 l=0.15
X3 WAKE.t0 LEAKG GND.t2 GND sky130_fd_pr__nfet_01v8 ad=0.5 pd=3 as=0.5 ps=3 w=1 l=8
X4 WAKE.t3 DONE GND.t3 GND sky130_fd_pr__nfet_01v8 ad=0.1596 pd=1.6 as=0.1554 ps=1.58 w=0.42 l=0.15
X5 WAKE.t4 GND.t0 sky130_fd_pr__cap_mim_m3_1 l=2 w=2
R0 PRE.t1 PRE 246.964
R1 PRE PRE.t0 315.137
R2 OK.t1 OK 246.964
R3 OK OK.t0 315.137
R4 GND.n0 GND.t3 258.716
R5 GND GND.n0 0.407231
R6 GND GND.t0 0.975087
R7 GND.n0 GND.t2 237.827
R8 OUT.t0 OUT 245.868
R9 EVT EVT.t0 249.087
R10 WAKE.n3 WAKE.t1 254.381
R11 WAKE.n0 WAKE.n3 0.721654
R12 WAKE.n2 WAKE.n0 0.659154
R13 WAKE.n3 WAKE.t0 234.846
R14 WAKE.n2 WAKE.t3 252.166
R15 WAKE WAKE.n2 1.01973
R16 WAKE WAKE.n1 0.0894423
R17 WAKE WAKE.n1 0.0389615
R18 WAKE.n1 WAKE.t5 319.495
R19 WAKE WAKE.n1 0.214442
R20 WAKE.n1 WAKE.t4 10.6474
R21 WAKE.n0 WAKE.t2 254.381
C0 GND WAKE 1.62264f
C1 OK LEAKG 0
C2 DONE OUT 0.00121f
C3 PRE WAKE 0.03442f
C4 GND DONE 0.00908f
C5 EVT WAKE 0.01568f
C6 EVT DONE 0
C7 WAKE LEAKG 0.27139f
C8 GND OUT 0.00531f
C9 GND PRE 0.00478f
C10 EVT OUT 0.0183f
C11 GND EVT 0.01468f
C12 OK WAKE 0.07225f
C13 GND LEAKG 0.02741f
C14 OK DONE 0.01045f
C15 PRE LEAKG 0.00529f
C16 GND OK 0.0054f
C17 DONE WAKE 0.04156f
C18 OK PRE 0.03638f
C19 OUT WAKE 0.02385f
C20 PRE GND 0.61994f
C21 OK GND 0.60902f
C22 GND GND 3.80273f
C23 OUT GND 0.15134f
C24 EVT GND 0.15273f
C25 WAKE GND 5.2187f
C26 WAKE.t1 GND 0.01416f
C27 WAKE.t2 GND 0.01713f
C28 WAKE.n0 GND 0.14487f
C29 WAKE.n1 GND 0.45162f
C30 WAKE.n2 GND 0.30955f
C31 WAKE.t3 GND 0.17687f
C32 WAKE.t0 GND 0.96431f
C33 WAKE.n3 GND 0.6853f
C34 EVT.t0 GND 0.01984f
C35 OUT.t0 GND 0.01982f
C36 GND.t3 GND 0.1822f
C37 GND.t2 GND 0.97303f
C38 GND.t0 GND 0.84689f
C39 GND.n0 GND 0.85756f
C40 OK.t1 GND 0.01733f
C41 PRE.t1 GND 0.01125f
.ends
