* v15D fast charge accumulation linear SPICE sanity check
IRES 0 d PWL(1e-09 0 1.001e-09 4e-09 2e-09 4e-09 2.001e-09 0 1.01e-07 0 1.01001e-07 4e-09 1.02e-07 4e-09 1.02001e-07 0 2.01e-07 0 2.01001e-07 4e-09 2.02e-07 4e-09 2.02001e-07 0 3.01e-07 0 3.01001e-07 4e-09 3.02e-07 4e-09 3.02001e-07 0 4.01e-07 0 4.01001e-07 4e-09 4.02e-07 4e-09 4.02001e-07 0 5.01e-07 0 5.01001e-07 4e-09 5.02e-07 4e-09 5.02001e-07 0 6.01e-07 0 6.01001e-07 4e-09 6.02e-07 4e-09 6.02001e-07 0 7.01e-07 0 7.01001e-07 4e-09 7.02e-07 4e-09 7.02001e-07 0 8.01e-07 0 8.01001e-07 4e-09 8.02e-07 4e-09 8.02001e-07 0 9.01e-07 0 9.01001e-07 4e-09 9.02e-07 4e-09 9.02001e-07 0 1.001e-06 0 1.001001e-06 4e-09 1.002e-06 4e-09 1.002001e-06 0 1.101e-06 0 1.101001e-06 4e-09 1.102e-06 4e-09 1.102001e-06 0 1.201e-06 0 1.201001e-06 4e-09 1.202e-06 4e-09 1.202001e-06 0 1.301e-06 0 1.301001e-06 4e-09 1.302e-06 4e-09 1.302001e-06 0)
CFE d 0 24e-18
CPAR d 0 20e-18
RLEAK d 0 120G
.tran 50p 12u
.meas tran V1 find v(d) at=50n
.meas tran V4 find v(d) at=350n
.meas tran V8 find v(d) at=750n
.meas tran V12 find v(d) at=1150n
.meas tran V14 find v(d) at=1350n
.meas tran V5U find v(d) at=5u
.meas tran V10U find v(d) at=10u
.end
