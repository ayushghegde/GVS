* NGSPICE file created from regional_boundary_v5_flat.ext - technology: sky130A

.subckt regional_boundary_v5_flat TEGLOBAL TELOCAL GND LRET LEASEWAKE SUB
X0 TELOCAL.t0 LEASEWAKE TEGLOBAL.t0 SUB sky130_fd_pr__nfet_01v8 ad=0.1596 pd=1.6 as=0.1554 ps=1.58 w=0.42 l=0.15
X1 LRET.t0 LEASEWAKE GND.t0 SUB sky130_fd_pr__nfet_01v8 ad=0.2394 pd=2.02 as=0.2331 ps=2 w=0.63 l=0.15
R0 LRET.t0 LRET 228.726
R1 GND GND.t0 231.13
R2 TELOCAL.t0 TELOCAL 245.868
R3 TEGLOBAL TEGLOBAL.t0 249.226
C0 GND TELOCAL 0.00759f
C1 LEASEWAKE LRET 0.0061f
C2 LEASEWAKE TEGLOBAL 0.00562f
C3 LEASEWAKE TELOCAL 0.02914f
C4 LEASEWAKE GND 0.0286f
C5 TEGLOBAL TELOCAL 0.0183f
C6 LRET GND 0.0183f
C7 LRET SUB 0.17535f
C8 GND SUB 0.14624f
C9 TELOCAL SUB 0.15294f
C10 TEGLOBAL SUB 0.1786f
C11 TEGLOBAL.t0 SUB 0.46663f
C12 TELOCAL.t0 SUB 0.4737f
C13 GND.t0 SUB 0.01684f
C14 LRET.t0 SUB 0.00764f
.ends
