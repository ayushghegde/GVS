* NGSPICE file created from local_group8_flat.ext - technology: sky130A
.subckt local_group8_flat VDD ROWB COLB GND0 GND1 OK DONE EVT0 OUT0 EVT1 OUT1 EVT2 OUT2 EVT3 OUT3 EVT4 OUT4 EVT5 OUT5 EVT6 OUT6 EVT7 OUT7 LEAKG
X0 OUT5.t0 WAKE.t6 EVT5.t0 GND1 sky130_fd_pr__nfet_01v8 ad=0.1596 pd=1.6 as=0.1554 ps=1.58 w=0.42 l=0.15
X1 OUT2.t0 WAKE.t7 EVT2.t0 GND1 sky130_fd_pr__nfet_01v8 ad=0.1596 pd=1.6 as=0.1554 ps=1.58 w=0.42 l=0.15
X2 a_0_930.t0 ROWB GND0.t0 GND1 sky130_fd_pr__nfet_01v8 ad=0.1596 pd=1.6 as=0.1554 ps=1.58 w=0.42 l=0.15
X3 a_0_930.t4 a_0_930.t3 WAKE.t2 GND1 sky130_fd_pr__nfet_01v8 ad=0.1596 pd=1.6 as=0.1554 ps=1.58 w=0.42 l=0.15
X4 OUT6.t0 WAKE.t8 EVT6.t0 GND1 sky130_fd_pr__nfet_01v8 ad=0.1596 pd=1.6 as=0.1554 ps=1.58 w=0.42 l=0.15
X5 OUT4.t0 WAKE.t12 EVT4.t0 GND1 sky130_fd_pr__nfet_01v8 ad=0.1596 pd=1.6 as=0.1554 ps=1.58 w=0.42 l=0.15
X6 OK.t1 OK.t0 WAKE.t1 GND1 sky130_fd_pr__nfet_01v8 ad=0.1596 pd=1.6 as=0.1554 ps=1.58 w=0.42 l=0.15
X7 WAKE.t4 GND1.t0 sky130_fd_pr__cap_mim_m3_1 l=2 w=2
X8 WAKE.t0 DONE GND1.t2 GND1 sky130_fd_pr__nfet_01v8 ad=0.1596 pd=1.6 as=0.1554 ps=1.58 w=0.42 l=0.15
X9 OUT0.t0 WAKE.t11 EVT0.t0 GND1 sky130_fd_pr__nfet_01v8 ad=0.1596 pd=1.6 as=0.1554 ps=1.58 w=0.42 l=0.15
X10 OUT1.t0 WAKE.t9 EVT1.t0 GND1 sky130_fd_pr__nfet_01v8 ad=0.1596 pd=1.6 as=0.1554 ps=1.58 w=0.42 l=0.15
X11 a_52_630.t0 ROWB VDD.t1 VDD.t0 sky130_fd_pr__pfet_01v8 ad=0.3192 pd=2.44 as=0.3108 ps=2.42 w=0.84 l=0.15
X12 WAKE.t3 LEAKG GND1.t3 GND1 sky130_fd_pr__nfet_01v8 ad=0.5 pd=3 as=0.5 ps=3 w=1 l=8
X13 a_52_630.t1 COLB a_0_930.t1 VDD.t2 sky130_fd_pr__pfet_01v8 ad=0.3192 pd=2.44 as=0.3108 ps=2.42 w=0.84 l=0.15
X14 OUT7.t0 WAKE.t10 EVT7.t0 GND1 sky130_fd_pr__nfet_01v8 ad=0.1596 pd=1.6 as=0.1554 ps=1.58 w=0.42 l=0.15
X15 a_0_930.t2 COLB GND0.t1 GND1 sky130_fd_pr__nfet_01v8 ad=0.1596 pd=1.6 as=0.1554 ps=1.58 w=0.42 l=0.15
X16 OUT3.t0 WAKE.t5 EVT3.t0 GND1 sky130_fd_pr__nfet_01v8 ad=0.1596 pd=1.6 as=0.1554 ps=1.58 w=0.42 l=0.15
R0 OUT3.t0 OUT3 245.79
R1 EVT3 EVT3.t0 249.132
R2 OUT5.t0 OUT5 245.79
R3 EVT5 EVT5.t0 249.132
R4 GND0.n0 GND0.t0 255.333
R5 GND0 GND0.n0 0.120692
R6 GND0.n0 GND0.t1 254.612
R7 OK.t1 OK 246.964
R8 OK OK.t0 315.137
R9 OUT2.t0 OUT2 245.79
R10 EVT2 EVT2.t0 249.132
R11 OUT6.t0 OUT6 245.79
R12 EVT6 EVT6.t0 249.132
R13 GND1.n0 GND1.t2 258.716
R14 GND1 GND1.n0 0.407231
R15 GND1 GND1.t0 0.975087
R16 GND1.n0 GND1.t3 237.827
R17 OUT1.t0 OUT1 245.79
R18 EVT1 EVT1.t0 249.132
R19 OUT7.t0 OUT7 245.79
R20 EVT7 EVT7.t0 249.132
R21 OUT0.t0 OUT0 245.868
R22 EVT0 EVT0.t0 249.087
R23 a_52_630.t0 a_52_630.t1 1283.27
R24 a_0_930.t1 a_0_930.n2 650.924
R25 a_0_930.n2 a_0_930.n0 1.52454
R26 a_0_930.n2 a_0_930.n1 20.219
R27 a_0_930.n1 a_0_930.t4 246.9
R28 a_0_930.n1 a_0_930.t3 314.856
R29 a_0_930.n0 a_0_930.t0 251.766
R30 a_0_930.n0 a_0_930.t2 251.043
R31 OUT4.t0 OUT4 245.79
R32 EVT4 EVT4.t0 249.132
R33 WAKE.t0 WAKE.n8 252.166
R34 WAKE.n0 WAKE.n1 0.721654
R35 WAKE.n8 WAKE.n0 0.659154
R36 WAKE.n2 WAKE.n8 1.01973
R37 WAKE WAKE.n2 0.0370169
R38 WAKE.n2 WAKE.n3 0.449938
R39 WAKE.n3 WAKE.n7 1.4649
R40 WAKE.n7 WAKE.n6 0.139923
R41 WAKE.n7 WAKE.t12 319.161
R42 WAKE.n6 WAKE.t9 318.709
R43 WAKE.n6 WAKE.t10 318.565
R44 WAKE.n6 WAKE.n5 0.716846
R45 WAKE.n5 WAKE.t7 318.709
R46 WAKE.n5 WAKE.t8 318.565
R47 WAKE.n5 WAKE.n4 0.716846
R48 WAKE.n4 WAKE.t5 318.709
R49 WAKE.n4 WAKE.t6 318.565
R50 WAKE.n3 WAKE.t11 318.726
R51 WAKE WAKE.n2 0.214442
R52 WAKE.n2 WAKE.t4 10.6474
R53 WAKE.n1 WAKE.t3 234.846
R54 WAKE.n1 WAKE.t2 254.381
R55 WAKE.n0 WAKE.t1 254.381
R56 VDD.n1 VDD.t1 645.943
R57 VDD VDD.n1 0.0632706
R58 VDD.n1 VDD.n0 383.807
R59 VDD.n0 VDD.t0 63.8065
R60 VDD.n0 VDD.t2 361.567
C0 ROWB COLB 0.35712f
C1 OUT0 GND1 0.00531f
C2 EVT1 WAKE 0.04146f
C3 WAKE EVT6 0.01373f
C4 ROWB GND0 0.00994f
C5 OUT0 WAKE 0.02958f
C6 GND1 DONE 0.00908f
C7 DONE WAKE 0.04437f
C8 GND1 VDD 0
C9 OUT7 EVT7 0.0183f
C10 EVT1 OUT1 0.0183f
C11 COLB DONE 0
C12 OUT7 WAKE 0.10258f
C13 OUT4 WAKE 0.01572f
C14 COLB VDD 0.25925f
C15 OUT2 OUT3 0.00828f
C16 OUT2 EVT2 0.0183f
C17 OUT2 OK 0
C18 EVT5 EVT6 0.00842f
C19 EVT3 OUT5 0.01922f
C20 GND0 VDD 0.06439f
C21 OUT4 OUT1 0.00828f
C22 EVT1 EVT4 0.00842f
C23 OUT2 WAKE 0.01572f
C24 OUT3 EVT3 0.0183f
C25 OUT6 EVT6 0.0183f
C26 EVT3 EVT2 0.00842f
C27 OUT5 WAKE 0.03552f
C28 OK EVT2 0
C29 ROWB VDD 0.26231f
C30 OUT1 OUT2 0.00828f
C31 EVT3 WAKE 0.02285f
C32 GND1 EVT0 0.01468f
C33 EVT0 WAKE 0.01929f
C34 OUT4 EVT4 0.0183f
C35 OUT0 DONE 0.00121f
C36 OUT3 WAKE 0.01688f
C37 OK GND1 0.0054f
C38 OUT6 OUT7 0.00828f
C39 OK WAKE 0.07871f
C40 EVT2 WAKE 0.04142f
C41 LEAKG OUT5 0.0025f
C42 EVT7 WAKE 0.01796f
C43 LEAKG EVT3 0.00248f
C44 COLB EVT0 0
C45 GND1 WAKE 1.64754f
C46 EVT1 OUT7 0.01922f
C47 COLB OK 0.00172f
C48 LEAKG OK 0
C49 OUT5 EVT5 0.0183f
C50 COLB GND1 0.05272f
C51 LEAKG GND1 0.02741f
C52 COLB WAKE 0.04742f
C53 LEAKG WAKE 0.27712f
C54 OUT1 WAKE 0.01572f
C55 OUT6 OUT5 0.00828f
C56 COLB GND0 0.00832f
C57 EVT5 WAKE 0.00933f
C58 OUT6 EVT2 0.01922f
C59 OUT6 OK 0
C60 ROWB GND1 0.01583f
C61 EVT4 WAKE 0.04765f
C62 ROWB WAKE 0.01326f
C63 OUT0 EVT0 0.0183f
C64 EVT0 DONE 0
C65 OUT6 WAKE 0.10059f
C66 LEAKG EVT5 0.00389f
C67 EVT1 EVT2 0.00842f
C68 OK EVT6 0
C69 OK DONE 0.01045f
C70 EVT7 EVT6 0.00842f
C71 OUT3 GND1 0.14163f
C72 EVT3 GND1 0.15765f
C73 OUT5 GND1 0.1678f
C74 EVT5 GND1 0.14435f
C75 GND0 GND1 1.00621f
C76 OK GND1 0.62915f
C77 OUT2 GND1 0.13584f
C78 EVT2 GND1 0.15707f
C79 OUT6 GND1 0.20073f
C80 EVT6 GND1 0.13525f
C81 GND1 GND1 3.72047f
C82 OUT1 GND1 0.13582f
C83 EVT1 GND1 0.15709f
C84 OUT7 GND1 0.21485f
C85 EVT7 GND1 0.15238f
C86 OUT0 GND1 0.16365f
C87 EVT0 GND1 0.16143f
C88 OUT4 GND1 0.14801f
C89 EVT4 GND1 0.17315f
C90 WAKE GND1 8.64221f
C91 VDD GND1 5.23556f
C92 VDD.t1 GND1 0.00713f
C93 VDD.t0 GND1 0.18285f
C94 VDD.t2 GND1 0.47806f
C95 VDD.n0 GND1 0.22179f
C96 VDD.n1 GND1 0.10776f
C97 WAKE.t0 GND1 0.1731f
C98 WAKE.t1 GND1 0.01914f
C99 WAKE.n0 GND1 0.12935f
C100 WAKE.t2 GND1 0.01822f
C101 WAKE.n1 GND1 0.61187f
C102 WAKE.t3 GND1 0.958f
C103 WAKE.n2 GND1 0.40016f
C104 WAKE.n3 GND1 0.19925f
C105 WAKE.n4 GND1 0.20704f
C106 WAKE.n5 GND1 0.23578f
C107 WAKE.n6 GND1 0.20413f
C108 WAKE.n7 GND1 0.23928f
C109 WAKE.n8 GND1 0.27639f
C110 EVT4.t0 GND1 0.02506f
C111 OUT4.t0 GND1 0.01738f
C112 a_0_930.t1 GND1 0.86518f
C113 a_0_930.t2 GND1 0.01186f
C114 a_0_930.n0 GND1 0.41991f
C115 a_0_930.t0 GND1 0.66139f
C116 a_0_930.t4 GND1 0.02149f
C117 a_0_930.n1 GND1 0.55574f
C118 a_0_930.n2 GND1 1.00102f
C119 a_52_630.t0 GND1 0.32031f
C120 a_52_630.t1 GND1 1.16004f
C121 EVT0.t0 GND1 0.0217f
C122 OUT0.t0 GND1 0.02349f
C123 EVT7.t0 GND1 0.01829f
C124 OUT7.t0 GND1 0.04373f
C125 EVT1.t0 GND1 0.03042f
C126 OUT1.t0 GND1 0.0195f
C127 GND1.t2 GND1 0.18172f
C128 GND1.t3 GND1 0.97668f
C129 GND1.t0 GND1 0.8874f
C130 GND1.n0 GND1 0.99503f
C131 EVT6.t0 GND1 0.01954f
C132 OUT6.t0 GND1 0.0453f
C133 EVT2.t0 GND1 0.03041f
C134 OUT2.t0 GND1 0.01951f
C135 OK.t1 GND1 0.02336f
C136 GND0.t0 GND1 0.65332f
C137 GND0.t1 GND1 0.00409f
C138 GND0.n0 GND1 0.12713f
C139 EVT5.t0 GND1 0.01868f
C140 OUT5.t0 GND1 0.02832f
C141 EVT3.t0 GND1 0.02467f
C142 OUT3.t0 GND1 0.01791f
.ends
