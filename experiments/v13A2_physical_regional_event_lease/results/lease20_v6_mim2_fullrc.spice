* NGSPICE file created from lease20_v6_mim2_flat.ext - technology: sky130A

.subckt lease20_v6_mim2_flat PRE OK DONE EVT OUT LEAKG GND
X0 OUT.t0 WAKE.t5 EVT.t0 GND sky130_fd_pr__nfet_01v8 ad=0.1596 pd=1.6 as=0.1554 ps=1.58 w=0.42 l=0.15
X1 PRE.t1 PRE.t0 WAKE.t1 GND sky130_fd_pr__nfet_01v8 ad=0.1596 pd=1.6 as=0.1554 ps=1.58 w=0.42 l=0.15
X2 WAKE.t3 DONE GND.t3 GND sky130_fd_pr__nfet_01v8 ad=0.1596 pd=1.6 as=0.1554 ps=1.58 w=0.42 l=0.15
X3 OK.t1 OK.t0 WAKE.t2 GND sky130_fd_pr__nfet_01v8 ad=0.1596 pd=1.6 as=0.1554 ps=1.58 w=0.42 l=0.15
X4 WAKE.t4 GND.t0 sky130_fd_pr__cap_mim_m3_1 l=2 w=2
X5 WAKE.t0 LEAKG GND.t2 GND sky130_fd_pr__nfet_01v8 ad=0.5 pd=3 as=0.5 ps=3 w=1 l=8
R0 PRE.t1 PRE 246.964
R1 PRE PRE.t0 315.137
R2 OK.t1 OK 246.964
R3 OK OK.t0 315.137
R4 GND.n0 GND.t3 258.716
R5 GND GND.n0 0.588
R6 GND GND.t0 1.06547
R7 GND.n0 GND.t2 238.007
R8 OUT.t0 OUT 245.868
R9 EVT EVT.t0 249.087
R10 WAKE.n3 WAKE.t1 254.381
R11 WAKE.n0 WAKE.n3 0.962038
R12 WAKE.n2 WAKE.n0 0.899538
R13 WAKE.n3 WAKE.t0 234.846
R14 WAKE.n2 WAKE.t3 252.166
R15 WAKE.n1 WAKE.n2 1.34906
R16 WAKE.n1 WAKE.t5 319.495
R17 WAKE WAKE.n1 0.0269423
R18 WAKE WAKE.t4 11.1017
R19 WAKE.n0 WAKE.t2 254.381
C0 WAKE LEAKG 0.27139f
C1 GND OUT 0.00289f
C2 GND PRE 0.00478f
C3 EVT OUT 0.0183f
C4 GND EVT 0.01067f
C5 OK WAKE 0.04995f
C6 GND LEAKG 0.02741f
C7 OK DONE 0.00593f
C8 PRE LEAKG 0.00529f
C9 GND OK 0.0046f
C10 DONE WAKE 0.03559f
C11 OK PRE 0.02023f
C12 OUT WAKE 0.01956f
C13 GND WAKE 1.62756f
C14 OK LEAKG 0
C15 DONE OUT 0
C16 PRE WAKE 0.03327f
C17 GND DONE 0.0081f
C18 EVT WAKE 0.01473f
C19 EVT DONE 0
C20 PRE GND 0.62287f
C21 OK GND 0.60636f
C22 GND GND 4.28597f
C23 OUT GND 0.15158f
C24 EVT GND 0.15428f
C25 WAKE GND 6.06365f
C26 WAKE.t1 GND 0.0123f
C27 WAKE.t2 GND 0.01347f
C28 WAKE.n0 GND 0.16053f
C29 WAKE.n1 GND 0.21894f
C30 WAKE.n2 GND 0.31714f
C31 WAKE.t3 GND 0.18026f
C32 WAKE.t0 GND 0.96177f
C33 WAKE.n3 GND 0.64435f
C34 EVT.t0 GND 0.01792f
C35 OUT.t0 GND 0.0174f
C36 GND.t3 GND 0.18479f
C37 GND.t2 GND 0.96917f
C38 GND.t0 GND 0.79479f
C39 GND.n0 GND 0.87168f
C40 OK.t1 GND 0.01123f
C41 PRE.t1 GND 0.00884f
.ends
